Level 3 - cmos inverter dc point
.model NMOD NMOS LEVEL=1 VTO=0.7 KP=80u LAMBDA=0.02
.model PMOD PMOS LEVEL=1 VTO=-0.7 KP=40u LAMBDA=0.02
VDD vdd 0 DC 5
VIN in 0 DC 2.5
MN out in 0 0 NMOD W=10u L=1u
MP out in vdd vdd PMOD W=20u L=1u
.op
.print op v(vdd) v(in) v(out) i(vdd)
.end
