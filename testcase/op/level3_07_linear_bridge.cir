Level 3 - linear bridge with two sources
V1 a 0 DC 12
V2 b 0 DC 3
R1 a x 1k
R2 x 0 2k
R3 x b 3k
R4 b y 1.5k
R5 y 0 2.2k
.op
.print op v(a) v(b) v(x) v(y) i(v1) i(v2)
.end
