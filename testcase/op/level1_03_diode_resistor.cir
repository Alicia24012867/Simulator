Level 1 - diode with resistor load
.model DMOD D IS=1e-14 N=1
V1 in 0 DC 1
R1 in out 1k
D1 out 0 DMOD
.op
.print op v(in) v(out) i(v1)
.end
