Level 3 - diode and nmos combined load
.model DMOD D IS=1e-14 N=1
.model NMOD NMOS LEVEL=1 VTO=0.7 KP=50u LAMBDA=0.02
VDD vdd 0 DC 5
VIN gate 0 DC 2
R1 vdd out 10k
D1 out 0 DMOD
M1 out gate 0 0 NMOD W=10u L=1u
.op
.print op v(vdd) v(gate) v(out) i(vdd)
.end
