Level 2 - npn common emitter
.model QN NPN IS=1e-16 BF=100 BR=1 NF=1 NR=1
VCC vcc 0 DC 5
VB base 0 DC 0.75
RC vcc coll 1k
Q1 coll base 0 QN
.op
.print op v(vcc) v(base) v(coll) i(vcc)
.end
