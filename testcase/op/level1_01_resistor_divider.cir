Level 1 - linear resistor divider
V1 in 0 DC 10
R1 in out 1k
R2 out 0 1k
.op
.print op v(in) v(out) i(v1)
.end
