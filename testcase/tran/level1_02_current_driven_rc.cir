Level 1 - current driven RC
I1 0 out DC 1m
R1 out 0 1k
C1 out 0 1u
.tran 100u 1m UIC
.print tran v(out)
.end
