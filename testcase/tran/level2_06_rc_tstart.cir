Level 2 - RC with delayed output start
V1 in 0 DC 5
R1 in out 2k
C1 out 0 500n
.tran 100u 1m 300u UIC
.print tran v(in) v(out) i(v1)
.end
